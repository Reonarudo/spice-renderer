* 12 V to 5 V buck converter, 100 kHz
.include models/buck.lib
VIN in 0 DC 12
VG gate 0 PULSE(12 0 0 10n 10n 4.2u 10u)
M1 sw gate in in PSW
D1 0 sw DSCH
L1 sw out 22u
C1 out 0 47u
RL out 0 5
.tran 0.1u 2m
