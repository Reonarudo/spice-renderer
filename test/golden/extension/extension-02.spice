VDD vdd 0 1.8
VIN in 0 PULSE(0 1.8 0 10p 10p 1n 2n)
M1 out in vdd vdd pch W=2u L=180n
M2 out in 0 0 nch W=1u L=180n
CL out 0 10f
.model nch NMOS
.model pch PMOS
